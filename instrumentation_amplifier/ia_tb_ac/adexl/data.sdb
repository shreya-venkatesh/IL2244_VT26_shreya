ADE simulation setup
Run mode: Monte Carlo Sampling
Tests:
  AC (off): instrumentation_amplifier/ia_tb_ac/schematic, simulator spectre
    Outputs: nil
  Noise (off): instrumentation_amplifier/ia_tb_ac/schematic, simulator spectre
    Outputs: vh('pss "/VOUT"); harmonic(db(vh('pss "/VOUT")) 1); harmonic(db(vh('pss "/VOUT")) 2); harmonic(mag(vh('pss "/VOUT")) 1); (harmonic(db(vh('pss "/VOUT")) 1) - harmonic(db(vh('pss "/VOUT")) 2))
  MC (off): instrumentation_amplifier/ia_tb_ac/schematic, simulator spectre
    Outputs: nil; Poles; Zeros
  Noise:1: instrumentation_amplifier/ia_tb_ac/schematic, simulator spectre
    Outputs: vh('pss "/VOUT"); harmonic(db(vh('pss "/VOUT")) 1); harmonic(db(vh('pss "/VOUT")) 2); harmonic(mag(vh('pss "/VOUT")) 1); (harmonic(db(vh('pss "/VOUT")) 1) - harmonic(db(vh('pss "/VOUT")) 2))
Global variables:
  VCM_AC = 1
  VCM_DC = 1.6
  VDD = 3.3
  VDD_STEP = 0
  VIN_AC = 1
  VIN_DC = 0
  VIN_STEP = 0
  VCM_AMP = 0
  VIN_AMP = 0
  VIN_FREQ = 50
  F = 4K
Corners (all switched off):
  model folders: /opt/pdk/ams/410/spectre/c35
  C0: temperature=-40 80; VDD=3.63 2.97; processOption.scs, cmos53.scs[cmoswo cmoswp cmosws cmoswz], res.scs[reswp resws], cap.scs[capwp capws]
Monte Carlo Sampling options: mcmethod=all, mcnumpoints=100, parasiticanalysis=0

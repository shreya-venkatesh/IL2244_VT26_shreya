ADE simulation setup
Test instrumentation_amplifier_ia_tb_ac_1: instrumentation_amplifier/ia_tb_ac/schematic, simulator spectre
  Models: /opt/pdk/ams/410/spectre/c35/processOption.scs, /opt/pdk/ams/410/spectre/c35/cmos53.scs[cmostm], /opt/pdk/ams/410/spectre/c35/res.scs[restm], /opt/pdk/ams/410/spectre/c35/cap.scs[captm], /opt/pdk/ams/410/spectre/c35/bip.scs[biptm], /opt/pdk/ams/410/spectre/c35/ind.scs[indtm], /opt/pdk/ams/410/spectre/c35/esddiode.scs[esddiodetm]
  Variables: VCM_AC = 0; VCM_AMP = 0; VCM_DC = 1.65; VDD = 3.3; VIN_AC = 1; VIN_AMP = 0; VIN_DC = 0; VIN_FREQ = 4k
  Temperature: 27
  Simulator options: reltol=100e-6 homotopy=all limit=delta additionalArgs=enable_pre_ver=yes ignorezerovar=yes
  Files: definitions /opt/pdk/ams/410/spectre/c35/soac/soac.scs
  Analysis dc: (saves the operating point)
  Analysis pss: engine=Shooting fund=4K harms=40 errpreset=conservative
  Analysis pnoise: start=0.01 stop=100k dec=20 fund=4K p=/VOUT maxsideband=10 noisetype=timeaverage
  Analysis pxf: start=0.01 stop=100K dec=20 fund=4K p=/VOUT sweeptype=relative relharmnum=0 sidebands=("0")
  Output V/V /V13; pxf dB20(V/V) = db(getData("/V13" ?result "pxf"))
  Output V/V /V12; pxf dB20(V/V) = db(getData("/V12" ?result "pxf"))
Test NoiseXF_MC: instrumentation_amplifier/ia_tb_ac/schematic, simulator spectre
  Models: /opt/pdk/ams/410/spectre/c35/processOption.scs, /opt/pdk/ams/410/spectre/c35/cmos53.scs[cmosmc], /opt/pdk/ams/410/spectre/c35/res.scs[resmc], /opt/pdk/ams/410/spectre/c35/cap.scs[capmc], /opt/pdk/ams/410/spectre/c35/bip.scs[bipmc], /opt/pdk/ams/410/spectre/c35/ind.scs[indmc], /opt/pdk/ams/410/spectre/c35/esddiode.scs[esddiodemc]
  Variables: VCM_AC = 0; VCM_AMP = 0; VCM_DC = 1.65; VDD = 3.3; VIN_AC = 1; VIN_AMP = 0; VIN_DC = 0; VIN_FREQ = 4k
  Temperature: 27
  Simulator options: reltol=100e-6 homotopy=all limit=delta additionalArgs=enable_pre_ver=yes ignorezerovar=yes
  Files: definitions /opt/pdk/ams/410/spectre/c35/soac/soac.scs
  Analysis dc: (saves the operating point)
  Analysis pss: engine=Shooting fund=4K harms=40 errpreset=conservative
  Analysis pnoise: start=0.01 stop=100k dec=20 fund=4K p=/VOUT maxsideband=10 noisetype=timeaverage
  Analysis pxf: start=0.01 stop=100K dec=20 fund=4K p=/VOUT sweeptype=relative relharmnum=0 sidebands=("0")
  Analysis pac: start=0.01 stop=10M dec=20 fund=4K sidebands=("0")
  Output V/V /V13; pxf dB20(V/V) = db(getData("/V13" ?result "pxf"))
  Output V/V /V12; pxf dB20(V/V) = db(getData("/V12" ?result "pxf"))
  Output (/VOUT)/(/net3 h=0)  pac dB20(V/V) = db((v("/VOUT" ?result "pac") / drplPacVolGnExpDen("v(\"/net3\" ?result \"pac\")" '(0) nil)))
  Output (/VOUT)/(/net6 h=0)  pac dB20(V/V) = db((v("/VOUT" ?result "pac") / drplPacVolGnExpDen("v(\"/net6\" ?result \"pac\")" '(0) nil)))
  Output v /VOUT; pac mag(V) = vh('pac "/VOUT")
  Signals: /VOUT
Test VIN: instrumentation_amplifier/ia_tb_ac/schematic, simulator spectre
  Models: /opt/pdk/ams/410/spectre/c35/processOption.scs, /opt/pdk/ams/410/spectre/c35/cmos53.scs[cmostm], /opt/pdk/ams/410/spectre/c35/res.scs[restm], /opt/pdk/ams/410/spectre/c35/cap.scs[captm], /opt/pdk/ams/410/spectre/c35/bip.scs[biptm], /opt/pdk/ams/410/spectre/c35/ind.scs[indtm], /opt/pdk/ams/410/spectre/c35/esddiode.scs[esddiodetm]
  Variables: VCM_AC = 0; VCM_AMP = 1m; VCM_DC = 1.65; VDD = 3.3; VIN_AC = 1; VIN_AMP = 1m; VIN_DC = 0; VIN_FREQ = 0
  Temperature: 27
  Simulator options: reltol=100e-6 homotopy=all limit=delta additionalArgs=enable_pre_ver=yes ignorezerovar=yes
  Files: definitions /opt/pdk/ams/410/spectre/c35/soac/soac.scs
  Analysis dc: (saves the operating point)
  Analysis pss: engine=Shooting fund=50 harms=40 errpreset=conservative
  Analysis pac: start=0.01 stop=10M dec=20 fund=50 sidebands=("0")
  Output V/V /V13; pxf dB20(V/V) = db(getData("/V13" ?result "pxf"))
  Output V/V /V12; pxf dB20(V/V) = db(getData("/V12" ?result "pxf"))
  Output v /VOUT; pss (V) = vtime('pss "/VOUT")
  Output (/VOUT)/(/net3 h=0)  pac dB20(V/V) = db((v("/VOUT" ?result "pac") / drplPacVolGnExpDen("v(\"/net3\" ?result \"pac\")" '(0) nil)))
  Output (/VOUT)/(/net6 h=0)  pac dB20(V/V) = db((v("/VOUT" ?result "pac") / drplPacVolGnExpDen("v(\"/net6\" ?result \"pac\")" '(0) nil)))
  Output v /VOUT; pac mag(V) = vh('pac "/VOUT")
Test NoiseXF: instrumentation_amplifier/ia_tb_ac/schematic, simulator spectre
  Models: /opt/pdk/ams/410/spectre/c35/processOption.scs, /opt/pdk/ams/410/spectre/c35/cmos53.scs[cmostm], /opt/pdk/ams/410/spectre/c35/res.scs[restm], /opt/pdk/ams/410/spectre/c35/cap.scs[captm], /opt/pdk/ams/410/spectre/c35/bip.scs[biptm], /opt/pdk/ams/410/spectre/c35/ind.scs[indtm], /opt/pdk/ams/410/spectre/c35/esddiode.scs[esddiodetm]
  Variables: VCM_AC = 0; VCM_AMP = 0; VCM_DC = 1.65; VDD = 3.3; VIN_AC = 0; VIN_AMP = 1m; VIN_DC = 0; VIN_FREQ = 4k
  Temperature: 27
  Simulator options: reltol=100e-6 homotopy=all limit=delta additionalArgs=enable_pre_ver=yes ignorezerovar=yes
  Files: definitions /opt/pdk/ams/410/spectre/c35/soac/soac.scs
  Analysis dc: (saves the operating point)
  Analysis pss: engine=Shooting fund=4K harms=40 errpreset=conservative
  Analysis pac: start=0.01 stop=10M dec=20 fund=4K sidebands=("0")
  Output V/V /V13; pxf dB20(V/V) = db(getData("/V13" ?result "pxf"))
  Output V/V /V12; pxf dB20(V/V) = db(getData("/V12" ?result "pxf"))
  Output (/VOUT)/(/net3 h=0)  pac dB20(V/V) = db((v("/VOUT" ?result "pac") / drplPacVolGnExpDen("v(\"/net3\" ?result \"pac\")" '(0) nil)))
  Output (/VOUT)/(/net6 h=0)  pac dB20(V/V) = db((v("/VOUT" ?result "pac") / drplPacVolGnExpDen("v(\"/net6\" ?result \"pac\")" '(0) nil)))
  Output v /VOUT VDD=2.97; pac mag(V) = vh('pac "/VOUT")
  Output v /VOUT VDD=3.63; pac mag(V) = vh('pac "/VOUT")
  Output (/VOUT)/(/net3 h=0)  pac mag(V/V) = (v("/VOUT" ?result "pac") / drplPacVolGnExpDen("v(\"/net3\" ?result \"pac\")" '(0) nil))
  Signals: /VOUT

ADE simulation setup
Run mode: Single Run, Sweeps and Corners
Tests:
  NoiseXF: instrumentation_amplifier/ia_tb_ac/schematic, simulator spectre
    Variables: VCM_AC = 0; VCM_AMP = 0; VCM_DC = 1.65; VDD = 3.3; VIN_AC = 0; VIN_AMP = 1m; VIN_DC = 0; VIN_FREQ = 4k
    Outputs: /VOUT
  VIN (off): instrumentation_amplifier/ia_tb_ac/schematic, simulator spectre
    Variables: VCM_AC = 0; VCM_AMP = 1m; VCM_DC = 1.65; VDD = 3.3; VIN_AC = 1; VIN_AMP = 1m; VIN_DC = 0; VIN_FREQ = 0
  NoiseXF_MC (off): instrumentation_amplifier/ia_tb_ac/schematic, simulator spectre
    Variables: VCM_AC = 0; VCM_AMP = 0; VCM_DC = 1.65; VDD = 3.3; VIN_AC = 1; VIN_AMP = 0; VIN_DC = 0; VIN_FREQ = 4k
    Outputs: /VOUT
Corners (all switched off):
  model folders: /opt/pdk/ams/410/spectre/c35
  C0: temperature=-40 80; VDD=3.63 2.97; processOption.scs, cmos53.scs[cmoswo cmoswp cmosws cmoswz], res.scs[reswp resws], cap.scs[capwp capws]

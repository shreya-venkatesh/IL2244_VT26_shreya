ADE simulation setup
Run mode: Single Run, Sweeps and Corners
Tests:
  instrumentation_amplifier:CBIA_1:1: instrumentation_amplifier/CBIA_1/schematic, simulator spectre
    Outputs: (v / VOUT); VDC("/VOUT"); db(vfreq('ac "/VOUT"))
Global variables:
  VCM_AC = 0
  VCM_DC = 1.6
  VIN_AC = 1
  VIN_DC = 0

ADE simulation setup
Run mode: Monte Carlo Sampling
Tests:
  Transient (off): instrumentation_amplifier/ia_new_tb/schematic, simulator spectre
  MC: instrumentation_amplifier/ia_new_tb/schematic, simulator spectre
Global variables:
  VCM_AC = 0
  VCM_AMP = 0
  VCM_DC = 1.65
  VDD = 3.3
  VDD_PULSE = 0
  VDD_PULSE_RT = 1m
  VIN_AC = 0
  VIN_AMP = 1m
  VIN_DC = 300m
  VIN_FREQ = 50
  VIN_PULSE = 0
  F = 500
Corners (all switched off):
  model folders: /opt/pdk/ams/410/spectre/c35
  C0: temperature=-40 80; VDD=2.97 3.63; processOption.scs, cmos53.scs[cmosws cmoswp cmoswo cmoswz], res.scs[reswp resws], cap.scs[capwp capws], bip.scs[biptm], ind.scs[indtm], esddiode.scs[esddiodetm]
  C0_VDD (off): temperature=-40 80; processOption.scs, cmos53.scs[cmosws cmoswp cmoswo cmoswz], res.scs[reswp resws], cap.scs[capwp capws], bip.scs[biptm], ind.scs[indtm], esddiode.scs[esddiodetm]
Monte Carlo Sampling options: mcmethod=all, mcnumpoints=100, parasiticanalysis=0

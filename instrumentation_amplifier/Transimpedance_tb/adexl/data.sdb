ADE simulation setup
Run mode: Single Run, Sweeps and Corners
Tests:
  instrumentation_amplifier:Transimpedance_tb:1: instrumentation_amplifier/Transimpedance_tb/schematic, simulator spectre
    Outputs: db(vfreq('ac "/VOUT"))
Global variables:
  VCM_AC = 0
  VCM_DC = 1.65
  VIN_AC = 1
  VIN_DC = 0
